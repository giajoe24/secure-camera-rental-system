* LE-53 drive circuit (same as lock_driver.asc)
* ngspice -b lock_driver_ngspice.cir
V1 p5v 0 5
Vgpio gpio 0 PULSE(0 3.3 1m 10n 10n 10m 30m)
Rg gpio gate 100
Rpd gate 0 10k
Rcoil p5v mid 12.5
Lcoil mid sense 10m
Vsense sense drain 0
M1 drain gate 0 0 NMOS_LL
D1 drain p5v D_FLY
.model NMOS_LL VDMOS(Vto=1.2 Kp=8 Rd=20m Rs=10m Rg=2 Cgdmax=150p Cgdmin=15p Cgs=250p Cjo=80p Is=1e-12 Rb=20m)
.model D_FLY D(Is=31.7u Rs=51m N=1.373 Cjo=110p M=0.35 Eg=0.69 Xti=2)
.tran 1u 30m
.control
run
meas tran vmax MAX v(drain)
meas tran ion FIND i(Vsense) AT=10m
meas tran vds_on FIND v(drain) AT=10m
quit
.endc
.end
